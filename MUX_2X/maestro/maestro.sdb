ADE simulation setup
Run mode: Single Run, Sweeps and Corners
Tests:
  EE477_MUX_2X_1: EE477/MUX_2X/schematic, simulator spectre
