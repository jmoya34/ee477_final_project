ADE simulation setup
Test EE477_MUX_2X_1: EE477/MUX_2X/schematic, simulator spectre
  Models: /home/viterbi/01/ee577/CDS_GPDK45/gpdk045_v_5_0/gpdk045/../models/spectre/gpdk045.scs[mc]
  Temperature: 27
  Stimulus A: voltage bit rise=10p fall=10p period=1n data=01100110
  Stimulus B: voltage bit rise=10p fall=10p period=1n data=00111100
  Stimulus S: voltage bit rise=10p fall=10p period=1n data=00001111
  Stimulus vdd!: voltage dc dc=1
  Analysis tran: stop=9n
  Signals: /A, /B, /S, /out
Run mode: Single Run, Sweeps and Corners
