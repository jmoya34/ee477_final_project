ADE simulation setup
Run mode: Single Run, Sweeps and Corners
Tests:
  EE477_BoothEncoder_Radix4_8bit_1: EE477/BoothEncoder_Radix4_8bit/schematic, simulator spectre
    Outputs: /X0; /X1; /X2; /Y7; /Y0; /Y1; /Y2; /Y4; /Y3; /Y5; /Y6; /OUT0; /OUT1; /OUT2; "/OUT3"; /OUT3; /OUT4; /OUT5; /OUT6; /OUT7; /OUT8
