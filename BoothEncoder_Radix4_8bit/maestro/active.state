ADE simulation setup
Test EE477_BoothEncoder_Radix4_8bit_1: EE477/BoothEncoder_Radix4_8bit/schematic, simulator spectre
  Models: /home/viterbi/01/ee577/CDS_GPDK45/gpdk045_v_5_0/gpdk045/../models/spectre/gpdk045.scs[mc]
  Temperature: 27
  Files: vectors /home/viterbi/03/jryao/work_gpdk045/booth_encoder_test.vec
  Analysis tran: stop=10n errpreset=conservative
  Signals: /X0, /X1, /X2, /Y0, /Y1, /Y2, /Y3, /Y4, /Y5, /Y6, /Y7, /OUT0, /OUT1, /OUT2, /OUT3, /OUT4, /OUT5, /OUT6, /OUT7, /OUT8
Run mode: Single Run, Sweeps and Corners
