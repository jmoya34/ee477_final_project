ADE simulation setup
Run mode: Single Run, Sweeps and Corners
Tests:
  EE477_8bit_CLA_ADDER_1X_1: EE477/8bit_CLA_ADDER_1X/schematic, simulator spectre
