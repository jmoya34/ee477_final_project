ADE simulation setup
Test EE477_8bit_CLA_ADDER_1X_1: EE477/8bit_CLA_ADDER_1X/schematic, simulator spectre
  Models: /home/viterbi/01/ee577/CDS_GPDK45/gpdk045_v_5_0/gpdk045/../models/spectre/gpdk045.scs[mc]
  Temperature: 27
  Files: vectors /home/viterbi/02/vagutier/work_gpdk045/vector_files/8bit_adder_file_no_time_step.vec
  Analysis tran: stop=11n
  Signals: /A7, /A6, /A5, /A4, /A3, /A2, /A1, /A0, /B7, /B6, /B5, /B4, /B3, /B2, /B1, /B0, /Cin, /S7, /S6, /S5, /S4, /S3, /S2, /S1, /S0, /Cout
Run mode: Single Run, Sweeps and Corners
