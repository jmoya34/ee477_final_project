ADE simulation setup
Test custom_cells_INV_1X_1: custom_cells/INV_1X/av_extracted, simulator spectre
  Models: /home/viterbi/01/ee577/CDS_GPDK45/gpdk045_v_5_0/gpdk045/../models/spectre/gpdk045.scs[mc]
  Temperature: 27
  Stimulus in: voltage bit rise=10p fall=10p period=1n data=101010
  Stimulus vdd!: voltage dc dc=1
  Analysis tran: stop=10n
  Signals: /in, /out
Run mode: Single Run, Sweeps and Corners
