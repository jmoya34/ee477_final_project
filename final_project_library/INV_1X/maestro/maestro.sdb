ADE simulation setup
Run mode: Single Run, Sweeps and Corners
Tests:
  custom_cells_INV_1X_1: custom_cells/INV_1X/av_extracted, simulator spectre
