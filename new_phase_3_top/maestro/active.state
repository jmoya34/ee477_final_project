ADE simulation setup
Test custom_cells_new_phase_3_top_1: custom_cells/new_phase_3_top/schematic, simulator spectre
  Models: /home/viterbi/01/ee577/CDS_GPDK45/gpdk045_v_5_0/gpdk045/../models/spectre/gpdk045.scs[mc]
  Temperature: 27
  Files: vectors /home/viterbi/03/jryao/work_gpdk045/FinalTestCasesDemo.vec
  Stimulus vdd!: voltage dc dc=1
  Analysis tran: stop=33n errpreset=conservative
  Signals: /a7, /a6, /a5, /a4, /a3, /a2, /a1, /a0, /b7, /b6, /b5, /b4, /b3, /b2, /b1, /b0, /Q15, /Q14, /Q13, /Q12, /Q11, /Q10, /Q9, /Q8, /Q7, /Q6, /Q5, /Q4, /Q3, /Q2, /Q1, /Q0, /clk, /RST_b
Run mode: Single Run, Sweeps and Corners
