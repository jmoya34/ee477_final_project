ADE simulation setup
Run mode: Single Run, Sweeps and Corners
Tests:
  EE477_16bit_CLA_tb_1: EE477/16bit_CLA_tb/config, simulator spectre
    Outputs: /a_0; /a_1; /a_2; /a_3; /a_4; /a_5; /a_6; /a_7; /a_8; /a_9; /a_10; /a_11; /a_12; /a_13; /a_14; /a_15; /b_0; /b_1; /b_2; /b_3; /b_4; /b_5; /b_6; /b_7; /b_8; /b_9; /b_10; /b_11; /b_12; /b_13; /b_14; /b_15; /c_in; /c_out; /s_0; /s_1; /s_2; /s_3; /s_4; /s_5; /s_6; /s_7; /s_8; /s_9; /s_10; /s_11; /s_12; /s_13; /s_14; /s_15
