ADE simulation setup
Test EE477_16bit_CLA_tb_1: EE477/16bit_CLA_tb/schematic, simulator spectre
  Models: /home/viterbi/01/ee577/CDS_GPDK45/gpdk045_v_5_0/gpdk045/../models/spectre/gpdk045.scs[mc]
  Temperature: 27
  Files: vectors /home/viterbi/03/jryao/work_gpdk045/16bit_CLA_test.vec
  Analysis tran: stop=10n errpreset=conservative
  Signals: /a_15, /a_14, /a_13, /a_12, /a_11, /a_10, /a_9, /a_8, /a_7, /a_6, /a_5, /a_4, /a_3, /a_2, /a_1, /a_0, /b_15, /b_14, /b_13, /b_12, /b_11, /b_10, /b_9, /b_8, /b_7, /b_6, /b_5, /b_4, /b_3, /b_2, /b_1, /b_0, /c_in, /c_out, /s_15, /s_14, /s_13, /s_12, /s_11, /s_10, /s_9, /s_8, /s_7, /s_6, /s_5, /s_4, /s_3, /s_2, /s_1, /s_0
Run mode: Single Run, Sweeps and Corners
