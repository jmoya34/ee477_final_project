ADE simulation setup
Run mode: Single Run, Sweeps and Corners
Tests:
  EE477_MUX_1X_1: EE477/MUX_1X/schematic, simulator spectre
