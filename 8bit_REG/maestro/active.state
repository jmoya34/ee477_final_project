ADE simulation setup
Test EE477_8bit_REG_1: EE477/8bit_REG/schematic, simulator spectre
  Models: /home/viterbi/01/ee577/CDS_GPDK45/gpdk045_v_5_0/gpdk045/../models/spectre/gpdk045.scs[mc]
  Temperature: 27
  Stimulus vdd!: voltage dc dc=1
  Stimulus D0: voltage bit rise=10p fall=10p period=1n data=10101001001
  Stimulus clk: voltage bit rise=10p fall=10p period=1n data=010101010
  Stimulus D1: voltage bit rise=10p fall=10p period=1n data=10101001001
  Stimulus D2: voltage bit rise=10p fall=10p period=1n data=10101001001
  Stimulus D3: voltage bit rise=10p fall=10p period=1n data=10101001001
  Stimulus D4: voltage bit rise=10p fall=10p period=1n data=10101001001
  Stimulus D5: voltage bit rise=10p fall=10p period=1n data=10101001001
  Stimulus D6: voltage bit rise=10p fall=10p period=1n data=10101001001
  Stimulus D7: voltage bit rise=10p fall=10p period=1n data=10101001001
  Analysis tran: stop=10n
  Signals: /D0, /D1, /D2, /D3, /D4, /D5, /D6, /D7, /Q0, /Q1, /Q2, /Q3, /Q4, /Q5, /Q6, /Q7, /clk
Run mode: Single Run, Sweeps and Corners
