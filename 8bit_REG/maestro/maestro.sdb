ADE simulation setup
Run mode: Single Run, Sweeps and Corners
Tests:
  EE477_8bit_REG_1: EE477/8bit_REG/schematic, simulator spectre
