ADE simulation setup
Run mode: Single Run, Sweeps and Corners
Tests:
  EE477_NAND_1X_1: EE477/NAND_1X/schematic, simulator spectre
