ADE simulation setup
Test EE477_NAND_1X_1: EE477/NAND_1X/schematic, simulator spectre
  Models: /home/viterbi/01/ee577/CDS_GPDK45/gpdk045_v_5_0/gpdk045/../models/spectre/gpdk045.scs[mc]
  Temperature: 27
  Stimulus a: voltage bit rise=10p fall=10p period=1n data=0011
  Stimulus b: voltage bit rise=10p fall=10p period=1n data=0110
  Stimulus vdd!: voltage dc dc=1
  Analysis tran: stop=10n
  Signals: /a, /b, /out
Run mode: Single Run, Sweeps and Corners
