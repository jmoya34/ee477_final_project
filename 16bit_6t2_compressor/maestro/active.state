ADE simulation setup
Test EE477_16bit_6t2_compressor_1: EE477/16bit_6t2_compressor/schematic, simulator spectre
  Models: /home/viterbi/01/ee577/CDS_GPDK45/gpdk045_v_5_0/gpdk045/../models/spectre/gpdk045.scs[mc]
  Temperature: 27
  Files: vectors /home/viterbi/02/vagutier/work_gpdk045/vector_files/16bit_6t2_compressor.vec
  Analysis tran: stop=9n
  Signals: /A15, /A14, /A13, /A12, /A11, /A10, /A9, /A8, /A7, /A6, /A5, /A4, /A3, /A2, /A1, /A0, /B15, /B14, /B13, /B12, /B11, /B10, /B9, /B8, /B7, /B6, /B5, /B4, /B3, /B2, /B1, /B0, /C15, /C14, /C13, /C12, /C11, /C10, /C9, /C8, /C7, /C6, /C5, /C4, /C3, /C2, /C1, /C0, /D15, /D14, /D13, /D12, /D11, /D10, /D9, /D8, /D7, /D6, /D5, /D4, /D3, /D2, /D1, /D0, /E15, /E14, /E13, /E12, /E11, /E10, /E9, /E8, /E7, /E6, /E5, /E4, /E3, /E2, /E1, /E0, /F15, /F14, /F13, /F12, /F11, /F10, /F9, /F8, /F7, /F6, /F5, /F4, /F3, /F2, /F1, /F0, /OUT0_15, /OUT0_14, /OUT0_13, /OUT0_12, /OUT0_11, /OUT0_10, /OUT0_9, /OUT0_8, /OUT0_7, /OUT0_6, /OUT0_5, /OUT0_4, /OUT0_3, /OUT0_2, /OUT0_1, /OUT0_0, /OUT1_15, /OUT1_14, /OUT1_13, /OUT1_12, /OUT1_11, /OUT1_10, /OUT1_9, /OUT1_8, /OUT1_7, /OUT1_6, /OUT1_5, /OUT1_4, /OUT1_3, /OUT1_2, /OUT1_1, /OUT1_0
Run mode: Single Run, Sweeps and Corners
