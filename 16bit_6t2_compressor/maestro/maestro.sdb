ADE simulation setup
Run mode: Single Run, Sweeps and Corners
Tests:
  EE477_16bit_6t2_compressor_1: EE477/16bit_6t2_compressor/schematic, simulator spectre
