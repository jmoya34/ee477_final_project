ADE simulation setup
Test EE477_16bit_3t2_encoder_1: EE477/OLD_16bit_3t2_encoder/schematic, simulator spectre
  Models: /home/viterbi/01/ee577/CDS_GPDK45/gpdk045_v_5_0/gpdk045/../models/spectre/gpdk045.scs[mc]
  Temperature: 27
  Files: vectors /home/viterbi/02/vagutier/work_gpdk045/vector_files/16bit_3t2_encoder.vec
  Analysis tran: stop=10n
  Signals: /A0, /A1, /A2, /A3, /A4, /A5, /A6, /A7, /A8, /A9, /A10, /A11, /A12, /A13, /A14, /A15, /B0, /B1, /B2, /B3, /B4, /B5, /B6, /B7, /B8, /B9, /B10, /B11, /B12, /B13, /B14, /B15, /OUT0_0, /OUT0_1, /OUT0_2, /OUT0_3, /OUT0_4, /OUT0_5, /OUT0_6, /OUT0_7, /OUT0_8, /OUT0_9, /OUT0_10, /OUT0_11, /OUT0_12, /OUT0_13, /OUT0_14, /OUT0_15, /C0, /C1, /C2, /C3, /C4, /C5, /C6, /C7, /C8, /C9, /C10, /C11, /C12, /C13, /C14, /C15, /gnd!, /I64/vdd! (terminal), /V0/MINUS (terminal), /V0/PLUS (terminal), /I66/gnd! (terminal), /OUT1_0, /OUT1_1, /OUT1_2, /OUT1_3, /OUT1_4, /OUT1_5, /OUT1_6, /OUT1_7, /OUT1_8, /OUT1_9, /OUT1_10, /OUT1_11, /OUT1_12, /OUT1_13, /OUT1_14, /OUT1_15
Run mode: Single Run, Sweeps and Corners
