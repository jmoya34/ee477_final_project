ADE simulation setup
Run mode: Single Run, Sweeps and Corners
Tests:
  EE477_16bit_3t2_encoder_1: EE477/OLD_16bit_3t2_encoder/schematic, simulator spectre
