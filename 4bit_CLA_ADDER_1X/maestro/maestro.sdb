ADE simulation setup
Run mode: Single Run, Sweeps and Corners
Tests:
  EE477_4bit_p_g_ADDER_1X_1: EE477/4bit_CLA_ADDER_1X/schematic, simulator spectre
