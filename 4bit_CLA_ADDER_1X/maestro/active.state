ADE simulation setup
Test EE477_4bit_p_g_ADDER_1X_1: EE477/4bit_CLA_ADDER_1X/schematic, simulator spectre
  Models: /home/viterbi/01/ee577/CDS_GPDK45/gpdk045_v_5_0/gpdk045/../models/spectre/gpdk045.scs[mc]
  Temperature: 27
  Stimulus vdd!: voltage dc dc=1
  Stimulus B3: voltage bit rise=10p fall=10p period=1n data=0100
  Stimulus A3: voltage bit rise=10p fall=10p period=1n data=0111
  Stimulus B2: voltage bit rise=10p fall=10p period=1n data=0100
  Stimulus A2: voltage bit rise=10p fall=10p period=1n data=0111
  Stimulus B1: voltage bit rise=10p fall=10p period=1n data=0101
  Stimulus A1: voltage bit rise=10p fall=10p period=1n data=0110
  Stimulus B0: voltage bit rise=10p fall=10p period=1n data=0111
  Stimulus A0: voltage bit rise=10p fall=10p period=1n data=0100
  Stimulus Cin: voltage bit rise=10p fall=10p period=1n data=0101
  Analysis tran: stop=5n
  Signals: /A0, /B0, /A1, /B1, /A2, /B2, /A3, /B3, /Cin, /Cout, /S3, /S2, /S1, /S0
Run mode: Single Run, Sweeps and Corners
