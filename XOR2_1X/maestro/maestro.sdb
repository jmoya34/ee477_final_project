ADE simulation setup
Run mode: Single Run, Sweeps and Corners
Tests:
  EE477_XOR2_1X_1: EE477/XOR2_1X/schematic, simulator spectre
