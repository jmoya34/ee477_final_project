ADE simulation setup
Test EE477_XOR2_1X_1: EE477/XOR2_1X/schematic, simulator spectre
  Models: /home/viterbi/01/ee577/CDS_GPDK45/gpdk045_v_5_0/gpdk045/../models/spectre/gpdk045.scs[mc]
  Temperature: 27
  Stimulus A: voltage bit rise=10p fall=10p period=1n data=00110110010
  Stimulus B: voltage bit rise=10p fall=10p period=1n data=01100011010
  Stimulus vdd!: voltage dc dc=1
  Analysis tran: stop=13n
  Signals: /A, /B, /OUT
Run mode: Single Run, Sweeps and Corners
