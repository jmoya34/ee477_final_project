ADE simulation setup
Run mode: Single Run, Sweeps and Corners
Tests:
  EE477_DFF_1x_1: EE477/DFF_1x/schematic, simulator spectre
