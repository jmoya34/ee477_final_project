ADE simulation setup
Test EE477_DFF_1x_1: EE477/DFF_1x/schematic, simulator spectre
  Models: /home/viterbi/01/ee577/CDS_GPDK45/gpdk045_v_5_0/gpdk045/../models/spectre/gpdk045.scs[mc]
  Temperature: 27
  Stimulus D: voltage bit rise=10p fall=10p period=1n data=0011000111
  Stimulus CLK: voltage bit rise=10p fall=10p period=500.0p data=01010101010101010101
  Stimulus vdd!: voltage dc dc=1
  Analysis tran: stop=11n
  Signals: /Q, /CLK, /D
Run mode: Single Run, Sweeps and Corners
