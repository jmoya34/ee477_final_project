ADE simulation setup
Run mode: Single Run, Sweeps and Corners
Tests:
  EE477_NOR_1X_1: EE477/NOR_1X/schematic, simulator spectre
