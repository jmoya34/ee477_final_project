ADE simulation setup
Run mode: Single Run, Sweeps and Corners
Tests:
  EE477_ADDER_1X_1: EE477/1bit_prop_ADDER_1X/schematic, simulator spectre
