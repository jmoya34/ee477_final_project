ADE simulation setup
Test EE477_ADDER_1X_1: EE477/1bit_prop_ADDER_1X/schematic, simulator spectre
  Models: /home/viterbi/01/ee577/CDS_GPDK45/gpdk045_v_5_0/gpdk045/../models/spectre/gpdk045.scs[mc]
  Temperature: 27
  Stimulus b: voltage bit rise=10p fall=10p period=1n data=111
  Stimulus cin: voltage bit rise=10p fall=10p period=1n data=010
  Stimulus a: voltage bit rise=10p fall=10p period=1n data=000
  Analysis tran: stop=4n
  Signals: /a, /b, /cin, /S, /OUT
Run mode: Single Run, Sweeps and Corners
