ADE simulation setup
Run mode: Single Run, Sweeps and Corners
Tests:
  EE477_INV_1X_1: EE477/INV_1X/schematic, simulator spectre
