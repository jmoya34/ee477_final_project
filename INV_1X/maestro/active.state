ADE simulation setup
Test EE477_INV_1X_1: EE477/INV_1X/schematic, simulator spectre
  Models: /home/viterbi/01/ee577/CDS_GPDK45/gpdk045_v_5_0/gpdk045/../models/spectre/gpdk045.scs[mc]
  Temperature: 27
  Stimulus vdd!: voltage dc dc=1
  Stimulus in: voltage bit rise=10p fall=10p period=1n data=101010
  Analysis tran: stop=10n
  Signals: /in, /out
Run mode: Single Run, Sweeps and Corners
