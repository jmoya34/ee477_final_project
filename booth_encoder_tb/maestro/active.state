ADE simulation setup
Test EE477_booth_encoder_tb_1: EE477/booth_encoder_tb/schematic, simulator spectre
  Models: /home/viterbi/01/ee577/CDS_GPDK45/gpdk045_v_5_0/gpdk045/../models/spectre/gpdk045.scs[mc]
  Temperature: 27
  Files: vectors /home/viterbi/03/jryao/work_gpdk045/booth_encoder_test.vec
  Analysis tran: stop=10n errpreset=conservative
  Signals: /x_0, /x_1, /x_2, /y_0, /y_1, /y_2, /y_3, /y_4, /y_5, /y_6, /y_7, /o0, /o1, /o2, /o3, /o4, /o5, /o6, /o7, /o8
Run mode: Single Run, Sweeps and Corners
