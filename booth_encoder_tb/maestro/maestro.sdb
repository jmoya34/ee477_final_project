ADE simulation setup
Run mode: Single Run, Sweeps and Corners
Tests:
  EE477_booth_encoder_tb_1: EE477/booth_encoder_tb/config, simulator spectre
    Outputs: "/x"; "/x_1"; "/x_2"; "/y_0"; "/y_1"; "/y_2"; "/y_3"; "/x_0"; /x_0; /x_1; /x_2; /y_0; /y_1; /y_2; /y_3; /y_4; /y_5; /y_6; /y_7; /o0; /o1; /o2; /o3; /o4; /o5; /o6; /o7; /o8
