ADE simulation setup
Test EE477_DFF_RESET_1x_1: EE477/DFF_RESET_1x/schematic, simulator spectre
  Models: /home/viterbi/01/ee577/CDS_GPDK45/gpdk045_v_5_0/gpdk045/../models/spectre/gpdk045.scs[mc]
  Temperature: 27
  Stimulus D: voltage bit rise=10p fall=10p period=1n data=011110000
  Stimulus CLK: voltage bit rise=10p fall=10p period=1n data=010101010
  Stimulus RST_b: voltage bit rise=10p fall=10p period=1n data=000000000
  Stimulus vdd!: voltage dc dc=1
  Analysis tran: stop=10n
  Signals: /D, /CLK, /RST_b, /Q
Run mode: Single Run, Sweeps and Corners
