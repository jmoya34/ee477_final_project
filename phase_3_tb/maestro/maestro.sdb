ADE simulation setup
Run mode: Single Run, Sweeps and Corners
Tests:
  custom_cells_phase_3_tb_1: custom_cells/phase_3_tb/schematic, simulator spectre
