ADE simulation setup
Test custom_cells_phase_3_tb_1: custom_cells/phase_3_tb/schematic, simulator spectre
  Models: /home/viterbi/01/ee577/CDS_GPDK45/gpdk045_v_5_0/gpdk045/../models/spectre/gpdk045.scs[mc]
  Temperature: 27
  Files: vectors /home/viterbi/02/vagutier/work_gpdk045/vector_files/16bit_MAC_tb.vec
  Analysis tran: stop=23n
  Signals: /A7, /A6, /A5, /A4, /A3, /A2, /A1, /A0, /B7, /B6, /B5, /B4, /B3, /B2, /B1, /B0, /CLK, /RST_b, /S15_out, /S14_out, /S13_out, /S12_out, /S11_out, /S10_out, /S9_out, /S8_out, /S7_out, /S6_out, /S5_out, /S4_out, /S3_out, /S2_out, /S1_out, /S0_out
Run mode: Single Run, Sweeps and Corners
